# Ansys Electronics Desktop project, version 2022.1
materials:
  vacuum: permittivity=1
  steel_1008: permeability{HUnit=A_per_meter BUnit=tesla curve (0, 0) (159.2, 0.2402) (318.3, 0.8654) (477.5, 1.1106) (636.6, 1.2458) (795.8, 1.331) (1591.5, 1.5) (3183.1, 1.6) (4774.6, 1.683) (6366.2, 1.741) (7957.7, 1.78) (15915.5, 1.905) (31831, 2.025) (47746.5, 2.085) (63662, 2.13) (79577.5, 2.165) (159155, 2.28) (318310, 2.485) (397887, 2.5851)} conductivity=2000000
  D21_50: permeability{HUnit=A_per_meter BUnit=tesla curve (0, 0) (140, 0.4) (155, 0.45) (171, 0.5) (191, 0.55) (212, 0.6) (237, 0.65) (267, 0.7) (302, 0.75) (340, 0.8) (380, 0.85) (425, 0.9) (476, 0.95) (536, 1) (602, 1.05) (675, 1.1) (765, 1.15) (880, 1.2) (1020, 1.25) (1200, 1.3) (1450, 1.35) (1740, 1.4) (2160, 1.45) (2800, 1.5) (3850, 1.55) (5290, 1.6) (6920, 1.65) (8800, 1.7) (11000, 1.75) (13800, 1.8) (17300, 1.85) (21400, 1.9) (25000, 1.95) (30000, 2)} core_loss_type="Electrical Steel" core_loss_kh=366 core_loss_kc=0.822 core_loss_ke=0.91 mass_density=7820
  copper: permeability=0.999991 conductivity=58000000

design Maxwell2DDesign1 (Maxwell 2D, Transient, XY geometry, model units mm)
options: ModelDepth=1meter
variables:
  N = 7
  i = 15.8A
  N1 = 52
  i1 = 15.8A
  N2 = 4015
  i2 = 0.258A
geometry:
  coil_0 [copper] = rectangle(corner=(41mm, 2mm, 0mm), x_size=5mm, y_size=-4mm)
  Rectangle9 = rectangle(corner=(47mm, 2mm, 0mm), x_size=5mm, y_size=-4mm)
  coilRe_0 [copper] = Rectangle9.duplicate_around_axis(axis=Z, angle=(360/25) deg, total=25)  # copies kept: 3
  Rectangle9.delete()
  coil_0_1..coil_0_24 [copper] = coil_0.duplicate_around_axis(axis=Z, angle=(360/25) deg, total=25)
  coilRe_0_1..coilRe_0_24 [copper] = coilRe_0.duplicate_around_axis(axis=Z, angle=(360/25) deg, total=25)
  Circle4_2 = imported_body()
  rotor [D21_50] = imported_body()
  Rectangle11 = rectangle(corner=(11mm, 121mm, 0mm), x_size=-22mm, y_size=-75mm)
  Circle6 = circle(normal=Z, centre=(0mm, 0mm, 0mm), radius=57.002193mm)
  Rectangle11.subtract(Circle6)
  Rectangle11_1 [steel_1008] = Rectangle11.duplicate_around_axis(axis=Z, angle=180deg, total=2)
  Rectangle11_1.unite(Rectangle11, Circle4_2)
  Rectangle13 [copper] = rectangle(corner=(13mm, 112mm, 0mm), x_size=17mm, y_size=-37mm)
  Rectangle13_1 [copper] = Rectangle13.duplicate_mirror(point=(0mm, 90mm, 0mm), normal=(-1mm, 0mm, 0mm))
  Rectangle13_2 [copper] = Rectangle13.duplicate_mirror(point=(0mm, 0mm, 0mm), normal=(0mm, -1mm, 0mm))
  Rectangle13_1_1 [copper] = Rectangle13_1.duplicate_mirror(point=(0mm, 0mm, 0mm), normal=(0mm, -1mm, 0mm))
  Rectangle14 [copper] = rectangle(corner=(108mm, 46mm, 0mm), x_size=-32mm, y_size=-22mm)
  Rectangle14_1 [copper] = Rectangle14.duplicate_mirror(point=(90mm, 0mm, 0mm), normal=(0mm, -1mm, 0mm))
  Rectangle14_2 [copper] = Rectangle14.duplicate_mirror(point=(0mm, 0mm, 0mm), normal=(-1mm, 0mm, 0mm))
  Rectangle14_1_1 [copper] = Rectangle14_1.duplicate_mirror(point=(0mm, 0mm, 0mm), normal=(-1mm, 0mm, 0mm))
  Circle7 [vacuum] = circle(normal=Z, centre=(0mm, 0mm, 0mm), radius=56.035703mm)
  Circle8 [vacuum] = circle(normal=Z, centre=(0mm, 0mm, 0mm), radius=162.78821mm)
  Circle9 [steel_1008] = circle(normal=Z, centre=(0mm, 0mm, 0mm), radius=14.848569mm)
motion:
  MotionSetup1: Band Move_Type=Rotate Coordinate_System=Global Axis=Z Is_Positive=true InitPos=-115deg Angular_Velocity=2650rpm Objects=Circle7
  Moving1: Moving Objects=[rotor, coil_0, coilRe_0, coil_0_1..coil_0_24, coilRe_0_1..coilRe_0_24, Circle9]
boundaries and excitations:
  VectorPotential1: Vector Potential Edges=Circle7.edge(1 of 1) Value=0
  VectorPotential2: Vector Potential Edges=Circle8.edge(1 of 1) Value=0
  coil_rotor_1: Current Objects=coil_0 Current=N*i IsSolid=true IsPositive=true
  coil_rotor_2: Current Objects=coil_0_1 Current=N*i IsSolid=true IsPositive=true
  coil_rotor_3: Current Objects=coil_0_2 Current=N*i IsSolid=true IsPositive=true
  coil_rotor_4: Current Objects=coil_0_3 Current=N*i IsSolid=true IsPositive=true
  coil_rotor_5: Current Objects=coil_0_4 Current=N*i IsSolid=true IsPositive=true
  coil_rotor_6: Current Objects=coil_0_5 Current=N*i IsSolid=true IsPositive=true
  coil_rotor_7: Current Objects=coil_0_6 Current=N*i IsSolid=true IsPositive=true
  coil_rotor_8: Current Objects=coil_0_7 Current=N*i IsSolid=true IsPositive=true
  coil_rotor_9: Current Objects=coil_0_8 Current=N*i IsSolid=true IsPositive=true
  coil_rotor_10: Current Objects=coil_0_9 Current=N*i IsSolid=true IsPositive=true
  coil_rotor_11: Current Objects=coil_0_10 Current=N*i IsSolid=true IsPositive=true
  coil_rotor_12: Current Objects=coil_0_11 Current=N*i IsSolid=true IsPositive=true
  coil_rotor_13: Current Objects=coil_0_12 Current=N*i IsSolid=true IsPositive=true
  coil_rotor_14: Current Objects=coil_0_13 Current=N*i IsSolid=true IsPositive=true
  coil_rotor_15: Current Objects=coil_0_14 Current=N*i IsSolid=true IsPositive=true
  coil_rotor_16: Current Objects=coil_0_15 Current=N*i IsSolid=true IsPositive=true
  coil_rotor_17: Current Objects=coil_0_16 Current=N*i IsSolid=true IsPositive=true
  coil_rotor_18: Current Objects=coil_0_17 Current=N*i IsSolid=true IsPositive=true
  coil_rotor_19: Current Objects=coil_0_18 Current=N*i IsSolid=true IsPositive=true
  coil_rotor_20: Current Objects=coil_0_19 Current=N*i IsSolid=true IsPositive=true
  coil_rotor_21: Current Objects=coil_0_20 Current=N*i IsSolid=true IsPositive=true
  coil_rotor_22: Current Objects=coil_0_21 Current=N*i IsSolid=true IsPositive=true
  coil_rotor_23: Current Objects=coil_0_22 Current=N*i IsSolid=true IsPositive=true
  coil_rotor_24: Current Objects=coil_0_23 Current=N*i IsSolid=true IsPositive=true
  coil_rotor_25: Current Objects=coil_0_24 Current=N*i IsSolid=true IsPositive=true
  coil_rotor_re_1: Current Objects=coilRe_0 Current=N*i IsSolid=true IsPositive=false
  coil_rotor_re_2: Current Objects=coilRe_0_1 Current=N*i IsSolid=true IsPositive=false
  coil_rotor_re_3: Current Objects=coilRe_0_2 Current=N*i IsSolid=true IsPositive=false
  coil_rotor_re_4: Current Objects=coilRe_0_3 Current=N*i IsSolid=true IsPositive=false
  coil_rotor_re_5: Current Objects=coilRe_0_4 Current=N*i IsSolid=true IsPositive=false
  coil_rotor_re_6: Current Objects=coilRe_0_5 Current=N*i IsSolid=true IsPositive=false
  coil_rotor_re_7: Current Objects=coilRe_0_6 Current=N*i IsSolid=true IsPositive=false
  coil_rotor_re_8: Current Objects=coilRe_0_7 Current=N*i IsSolid=true IsPositive=false
  coil_rotor_re_9: Current Objects=coilRe_0_8 Current=N*i IsSolid=true IsPositive=false
  coil_rotor_re_10: Current Objects=coilRe_0_9 Current=N*i IsSolid=true IsPositive=false
  coil_rotor_re_11: Current Objects=coilRe_0_10 Current=N*i IsSolid=true IsPositive=false
  coil_rotor_re_12: Current Objects=coilRe_0_11 Current=N*i IsSolid=true IsPositive=false
  coil_rotor_re_13: Current Objects=coilRe_0_12 Current=N*i IsSolid=true IsPositive=false
  coil_rotor_re_14: Current Objects=coilRe_0_13 Current=N*i IsSolid=true IsPositive=false
  coil_rotor_re_15: Current Objects=coilRe_0_14 Current=N*i IsSolid=true IsPositive=false
  coil_rotor_re_16: Current Objects=coilRe_0_15 Current=N*i IsSolid=true IsPositive=false
  coil_rotor_re_17: Current Objects=coilRe_0_16 Current=N*i IsSolid=true IsPositive=false
  coil_rotor_re_18: Current Objects=coilRe_0_17 Current=N*i IsSolid=true IsPositive=false
  coil_rotor_re_19: Current Objects=coilRe_0_18 Current=N*i IsSolid=true IsPositive=false
  coil_rotor_re_20: Current Objects=coilRe_0_19 Current=N*i IsSolid=true IsPositive=false
  coil_rotor_re_21: Current Objects=coilRe_0_20 Current=N*i IsSolid=true IsPositive=false
  coil_rotor_re_22: Current Objects=coilRe_0_21 Current=N*i IsSolid=true IsPositive=false
  coil_rotor_re_23: Current Objects=coilRe_0_22 Current=N*i IsSolid=true IsPositive=false
  coil_rotor_re_24: Current Objects=coilRe_0_23 Current=N*i IsSolid=true IsPositive=false
  coil_rotor_re_25: Current Objects=coilRe_0_24 Current=N*i IsSolid=true IsPositive=false
  coil_comm: Current Objects=Rectangle13 Current=N1*i1 IsSolid=true IsPositive=true
  coil_comm_re: Current Objects=Rectangle13_1 Current=N1*i1 IsSolid=true IsPositive=false
  coil_comm1: Current Objects=Rectangle13_1_1 Current=N1*i1 IsSolid=true IsPositive=false
  coil_comm1_re: Current Objects=Rectangle13_2 Current=N1*i1 IsSolid=true IsPositive=true
  coil_field: Current Objects=Rectangle14 Current=N2*i2 IsSolid=true IsPositive=true
  coil_field_re: Current Objects=Rectangle14_1 Current=N2*i2 IsSolid=true IsPositive=false
  coil_field1: Current Objects=Rectangle14_1_1 Current=N2*i2 IsSolid=true IsPositive=false
  coil_field1_re: Current Objects=Rectangle14_2 Current=N2*i2 IsSolid=true IsPositive=true
mesh:
  rotor: LengthBased RefineInside Objects=rotor NumMaxElem=1000
  frame: LengthBased RefineInside Objects=Rectangle11_1 NumMaxElem=10000
  winding: LengthBased RefineInside Objects=[Rectangle14_2, coil_0, coil_0_1..coil_0_24, coilRe_0, coilRe_0_1..coilRe_0_24, Rectangle13, Rectangle13_1, Rectangle13_1_1, Rectangle13_2, Rectangle14, Rectangle14_1, Rectangle14_1_1] NumMaxElem=1000
  CylindricalGap1: CylindricalGap Objects=Circle7
  initial mesh: MeshMethod=AnsoftTAU
setups:
  Setup1: Transient NonlinearSolverResidual=0.0001 StopTime=0.01s TimeStep=0.001s SaveFieldsType=Custom SweepRanges{0.001s to 0.01s step 0.001s} NumberSolveSteps=1 RangeStart=0s RangeEnd=0.1s InitialTimeStep=0.002s MinTimeStep=0.001s MaxTimeStep=0.003s TimeStepErrTolerance=0.0001
field plots:
  Mag_B1: B over rotor, coil_0, coilRe_0, coil_0_1..coil_0_24, coilRe_0_1..coilRe_0_24, Rectangle11_1, Rectangle13, Rectangle13_1, Rectangle13_2, Rectangle13_1_1, Rectangle14, Rectangle14_1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 on Setup1 : Transient at Time=0.01s
reports:
  Torque Plot 1: asin(Moving1.Torque) vs Time on Setup1 : Transient
