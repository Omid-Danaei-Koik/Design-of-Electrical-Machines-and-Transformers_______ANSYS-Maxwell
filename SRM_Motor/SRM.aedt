# Ansys Electronics Desktop project, version 2022.1
materials:
  steel_1008: permeability{HUnit=A_per_meter BUnit=tesla curve (0, 0) (159.2, 0.2402) (318.3, 0.8654) (477.5, 1.1106) (636.6, 1.2458) (795.8, 1.331) (1591.5, 1.5) (3183.1, 1.6) (4774.6, 1.683) (6366.2, 1.741) (7957.7, 1.78) (15915.5, 1.905) (31831, 2.025) (47746.5, 2.085) (63662, 2.13) (79577.5, 2.165) (159155, 2.28) (318310, 2.485) (397887, 2.5851)} conductivity=2000000 mass_density=7872
  vacuum: permittivity=1
  steel_1008_2DSF0.950: permeability{HUnit=A_per_meter BUnit=tesla curve (0, 0) (159.2, 0.2282) (318.3, 0.82215) (477.5, 1.0551) (636.6, 1.18355) (795.8, 1.2645) (1591.5, 1.4251) (3183.1, 1.5202) (4774.6, 1.59915) (6366.2, 1.65435) (7957.7, 1.6915) (15915.5, 1.81075) (31831, 1.92575) (47746.5, 1.98375) (63662, 2.0275) (79577.5, 2.06175) (159155, 2.176) (318310, 2.38075) (397887, 2.48084) (1193660, 3.48179)} conductivity=2000000 mass_density=7478.4
  copper: permeability=0.999991 conductivity=58000000 mass_density=8933

design RMxprtDesign1 (RMxprt, Switched Reluctance Motor, model units mm)
machine:
  Machine: FrictionLoss=0W WindLoss=0W ReferenceSpeed=1500rpm ControlType=0 CircuitType=Full-Voltage
  Circuit: TriggerPulseWidth=120deg TransistorDrop=0V DiodeDrop=0V LeadAngleOfTrigger=0deg MaximumCurrent=0A MinimumCurrent=0A
  Stator: NumberOfPoles=12 Embrace=0.5 YorkThickness=11mm OuterDiameter=138mm InnerDiameter=90mm Length=84mm StackingFactor=0.95 SteelType=steel_1008
  Rotor: OuterDiameter=89.4mm InnerDiameter=30mm Length=84mm SteelType=steel_1008 NumberOfPoles=8 Embrace=0.4 YorkThickness=11mm StackingFactor=0.95
  Shaft: MagneticShaft
  Stator Winding: InsulationThickness=0.1mm EndAdjustment=0mm ParallelBranches=1 TurnsperPole=10 CoupledRatio=0 NumberOfStrands=0 WireWrap=0mm InterturnInsulation=0mm WireDiameter=3.081mm WireWidth=0mm WireThickness=0mm Gauge=0
setups:
  Setup1: SRM Motor RatedOutputPower=15W RatedVoltage=60V RatedSpeed=1500rpm OperatingTemperature=75cel LoadType=ConstPower

design MaxCir1 (Maxwell Circuit)
variables:
  Kle = 1
components:
  Winding_14 = Winding(Name=PhaseA)
  Winding_21 = Winding(Name=PhaseB)
  Winding_28 = Winding(Name=PhaseC)
  Res_35 = Res(Name=A R=0.0237052ohm)
  Res_42 = Res(Name=B R=0.0237052ohm)
  Res_49 = Res(Name=C R=0.0237052ohm)
  Ind_56 = Ind(Name=A L=4.25241e-06H*Kle)
  Ind_63 = Ind(Name=B L=4.25241e-06H*Kle)
  Ind_70 = Ind(Name=C L=4.25241e-06H*Kle)
  Ammeter_77 = Ammeter(Name=IA)
  Ammeter_84 = Ammeter(Name=IB)
  Ammeter_91 = Ammeter(Name=IC)
  VPulse_98 = VPulse(V1=-1 Td=0 Tr=0 Tf=0 Pw=15 Period=45 Type=POS)
  VPulse_105 = VPulse(V1=-1 Td=15 Tr=0 Tf=0 Pw=15 Period=45 Type=POS)
  VPulse_112 = VPulse(V1=-1 Td=30 Tr=0 Tf=0 Pw=15 Period=45 Type=POS)
  Res_119 = Res()
  Res_126 = Res()
  Res_133 = Res()
  VoltmeterG_140 = VoltmeterG(Name=Vc1)
  VoltmeterG_147 = VoltmeterG(Name=Vc2)
  VoltmeterG_154 = VoltmeterG(Name=Vc3)
  VDC_161 = VDC(V=30V)
  VDC_168 = VDC(V=30V)
  DIODE_175 = DIODE(MOD=DModel1)
  DIODE_182 = DIODE(MOD=DModel1)
  DIODE_189 = DIODE(MOD=DModel1)
  DIODE_196 = DIODE(MOD=DModel1)
  DIODE_203 = DIODE(MOD=DModel1)
  DIODE_210 = DIODE(MOD=DModel1)
  DIODE_217 = DIODE(MOD=DModel1)
  DIODE_224 = DIODE(MOD=DModel1)
  DIODE_231 = DIODE(MOD=DModel1)
  DIODE_238 = DIODE(MOD=DModel1)
  DIODE_245 = DIODE(MOD=DModel1)
  DIODE_252 = DIODE(MOD=DModel1)
  SW_V_259 = SW_V(ID_V=IVc1 MOD=SModel1)
  SW_V_266 = SW_V(ID_V=IVc1 MOD=SModel1)
  SW_V_273 = SW_V(ID_V=IVc2 MOD=SModel1)
  SW_V_280 = SW_V(ID_V=IVc2 MOD=SModel1)
  SW_V_287 = SW_V(ID_V=IVc3 MOD=SModel1)
  SW_V_294 = SW_V(ID_V=IVc3 MOD=SModel1)
  DIODE_Model_301 = DIODE_Model(IS=0.002585A DeviceName=DModel1)
  SW_VModel_308 = SW_VModel(Von=0V Voff=0V DeviceName=SModel1)
nets:
  0: VPulse_105.1, VPulse_98.1, VDC_168.0, VDC_161.1, VPulse_112.1
  net_10: Ammeter_77.1, Ind_56.0
  net_11: Ammeter_84.1, Ind_63.0
  net_12: Ammeter_91.1, Ind_70.0
  net_16: VPulse_98.0, VoltmeterG_140.0, Res_119.0
  net_17: VPulse_105.0, VoltmeterG_147.0, Res_126.0
  net_18: VoltmeterG_154.0, VPulse_112.0, Res_133.0
  net_19: Res_119.1, Res_126.1, Res_133.1
  net_22: DIODE_182.1, DIODE_196.1, DIODE_245.0, DIODE_210.1, DIODE_217.0, DIODE_231.0, VDC_161.0
  net_24: DIODE_189.0, DIODE_175.0, DIODE_203.0, SW_V_266.1, VDC_168.1, SW_V_280.1, SW_V_294.1
  net_25: DIODE_175.1, SW_V_259.1, Ammeter_77.0
  net_26: DIODE_189.1, SW_V_273.1, Ammeter_84.0
  net_27: DIODE_203.1, Ammeter_91.0, SW_V_287.1
  net_28: Winding_14.1, DIODE_182.0, DIODE_224.0
  net_29: Winding_21.1, DIODE_196.0, DIODE_238.0
  net_30: Winding_28.1, DIODE_210.0, DIODE_252.0
  net_31: DIODE_217.1, SW_V_259.0
  net_32: DIODE_224.1, SW_V_266.0
  net_33: DIODE_231.1, SW_V_273.0
  net_34: DIODE_238.1, SW_V_280.0
  net_35: DIODE_245.1, SW_V_287.0
  net_36: DIODE_252.1, SW_V_294.0
  net_4: Winding_14.0, Res_35.1
  net_5: Res_42.1, Winding_21.0
  net_6: Winding_28.0, Res_49.1
  net_7: Res_35.0, Ind_56.1
  net_8: Res_42.0, Ind_63.1
  net_9: Res_49.0, Ind_70.1

design Maxwell2DDesign1 (Maxwell 2D, Transient, XY geometry, model units mm)
options: ModelDepth=84mm
variables:
  fractions = 1
geometry:
  Band [vacuum] = user_primitive(RMxprt/Band, DiaGap=89.7mm, DiaYoke=30mm, Length=0mm, SegAngle=0deg, Fractions=1, HalfAxial=0, InfoCore=0)
  Shaft [steel_1008_2DSF0.950] = user_primitive(RMxprt/Band, DiaGap=89.7mm, DiaYoke=30mm, Length=0mm, SegAngle=0deg, Fractions=1, HalfAxial=0, InfoCore=100)
  OuterRegion [vacuum] = user_primitive(RMxprt/Band, DiaGap=89.7mm, DiaYoke=138mm, Length=0mm, SegAngle=0deg, Fractions=fractions, HalfAxial=0, InfoCore=100)
  Tool = user_primitive(RMxprt/Band, DiaGap=89.7mm, DiaYoke=138mm, Length=0mm, SegAngle=0deg, Fractions=fractions, HalfAxial=0, InfoCore=1)
  Stator [steel_1008_2DSF0.950] = user_primitive(RMxprt/SRMCore, DiaGap=90mm, DiaYoke=138mm, Length=0mm, Poles=12, ThkYoke=11mm, Embrace=0.5, Delta=0deg, EndExt=0mm, LenRegion=0mm, InfoCore=0)
  Coil_0 [copper] = user_primitive(RMxprt/SRMCore, DiaGap=90mm, DiaYoke=138mm, Length=0mm, Poles=12, ThkYoke=11mm, Embrace=0.5, Delta=0deg, EndExt=0mm, LenRegion=0mm, InfoCore=3)
  Coil_1, Coil_2 [copper], Coil_3..Coil_11 = Coil_0.duplicate_around_axis(axis=Z, angle=30deg, total=12)
  Coil_0.unite(Coil_3, Coil_6, Coil_9)
  Coil_1.unite(Coil_4, Coil_7, Coil_10)
  Coil_2.unite(Coil_5, Coil_8, Coil_11)
  CoilRe_0 [copper] = user_primitive(RMxprt/SRMCore, DiaGap=90mm, DiaYoke=138mm, Length=0mm, Poles=12, ThkYoke=11mm, Embrace=0.5, Delta=0deg, EndExt=0mm, LenRegion=0mm, InfoCore=4)
  CoilRe_1, CoilRe_2 [copper], CoilRe_3..CoilRe_11 = CoilRe_0.duplicate_around_axis(axis=Z, angle=30deg, total=12)
  CoilRe_0.unite(CoilRe_3, CoilRe_6, CoilRe_9)
  CoilRe_1.unite(CoilRe_4, CoilRe_7, CoilRe_10)
  CoilRe_2.unite(CoilRe_5, CoilRe_8, CoilRe_11)
  Rotor [steel_1008_2DSF0.950] = user_primitive(RMxprt/SRMCore, DiaGap=89.4mm, DiaYoke=30mm, Length=0mm, Poles=8, ThkYoke=11mm, Embrace=0.4, Delta=0deg, EndExt=0mm, LenRegion=0mm, InfoCore=0)
  InnerRegion [vacuum] = user_primitive(RMxprt/SRMCore, DiaGap=89.4mm, DiaYoke=30mm, Length=0mm, Poles=8, ThkYoke=11mm, Embrace=0.4, Delta=0deg, EndExt=0mm, LenRegion=0mm, InfoCore=100)
  Tool_1 = Tool.copy()
  Band.subtract(Tool_1)
  Tool_2 = Tool.copy()
  InnerRegion.subtract(Tool_2)
  Tool_3 = Tool.copy()
  Shaft.subtract(Tool_3)
  Tool_4 = Tool.copy()
  Stator.subtract(Tool_4)
  Tool_5 = Tool.copy()
  Coil_0.subtract(Tool_5)
  Tool_6 = Tool.copy()
  Coil_1.subtract(Tool_6)
  Tool_7 = Tool.copy()
  Coil_2.subtract(Tool_7)
  Tool_8 = Tool.copy()
  CoilRe_0.subtract(Tool_8)
  Tool_9 = Tool.copy()
  CoilRe_1.subtract(Tool_9)
  Tool_10 = Tool.copy()
  CoilRe_2.subtract(Tool_10)
  Rotor.subtract(Tool)
  Rotor.rotate(axis=Z, angle=-7deg)
  [Band, Shaft, OuterRegion, Stator, Coil_0, Coil_1, Coil_2, CoilRe_0, CoilRe_1, CoilRe_2, Rotor, InnerRegion].rotate(axis=Z, angle=-15deg)
  Polyline1 = polyline((0mm, 0mm, 0mm) (0mm, 55mm, 0mm))
  Polyline1.rotate(axis=Z, angle=-15deg)
motion:
  MotionSetup1: Band Move_Type=Rotate Coordinate_System=Global Axis=Z Is_Positive=true InitPos=15deg Angular_Velocity=1500rpm Objects=Band
  Moving1: Moving Objects=[Shaft, Rotor, InnerRegion]
boundaries and excitations:
  PhA_0: Coil Objects=Coil_0 Conductor_number=10 Winding=PhaseA PolarityType=Positive
  PhARe_0: Coil Objects=CoilRe_0 Conductor_number=10 Winding=PhaseA PolarityType=Negative
  PhB_0: Coil Objects=Coil_2 Conductor_number=10 Winding=PhaseB PolarityType=Positive
  PhBRe_0: Coil Objects=CoilRe_2 Conductor_number=10 Winding=PhaseB PolarityType=Negative
  PhC_0: Coil Objects=Coil_1 Conductor_number=10 Winding=PhaseC PolarityType=Positive
  PhCRe_0: Coil Objects=CoilRe_1 Conductor_number=10 Winding=PhaseC PolarityType=Negative
  PhaseA: Winding Group Type=External IsSolid=false Current=0A ParallelBranchesNum=1
  PhaseB: Winding Group Type=External IsSolid=false Current=0A ParallelBranchesNum=1
  PhaseC: Winding Group Type=External IsSolid=false Current=0A ParallelBranchesNum=1
  external circuit: "* Design: MaxCir1\"
mesh:
  SurfApprox_Main: SurfApproxBased Objects=[Stator, Rotor, Band, OuterRegion, InnerRegion, Shaft] CurvedSurfaceApproxChoice=ManualSettings SurfDev=0.069mm NormalDev=15deg
  CylindricalGap1: CylindricalGap Objects=Band
  initial mesh: MeshMethod=AnsoftTAU
setups:
  Setup1: Transient NonlinearSolverResidual=0.0001 StopTime=0.0006s TimeStep=3e-06s InitialTimeStep=0.002s MinTimeStep=0.001s MaxTimeStep=0.003s TimeStepErrTolerance=0.0001
reports:
  Torque: Moving1.Torque vs Time on Setup1 : Transient
  Currents: Current(PhaseA), Current(PhaseB), Current(PhaseC) vs Time on Setup1 : Transient
  Induced Voltages: InducedVoltage(PhaseA), InducedVoltage(PhaseB), InducedVoltage(PhaseC) vs Time on Setup1 : Transient
  Flux Linkages: FluxLinkage(PhaseA), FluxLinkage(PhaseB), FluxLinkage(PhaseC) vs Time on Setup1 : Transient
