# Ansys Electronics Desktop project, version 2022.1
materials:
  vacuum: permittivity=1
  lead: permeability=0.999983 conductivity=5000000
  M19_26G: permeability{HUnit=A_per_meter BUnit=tesla curve (0, 0) (22.28, 0.05) (25.46, 0.1) (31.83, 0.15) (47.74, 0.36) (63.66, 0.54) (79.57, 0.65) (159.15, 0.99) (318.3, 1.2) (477.46, 1.28) (636.61, 1.33) (795.77, 1.36) (1591.5, 1.44) (3183, 1.52) (4774.6, 1.58) (6366.1, 1.63) (7957.7, 1.67) (15915, 1.8) (31830, 1.9) (111407, 2) (190984, 2.1) (350138, 2.3) (509292, 2.5)} conductivity=1960000 core_loss_type="Electrical Steel" core_loss_kh=164.2 core_loss_kc=0.712 core_loss_ke=0.82 mass_density=7650
  copper: permeability=0.999991 conductivity=58000000

design Maxwell3DDesign1 (Maxwell 3D, Transient, model units mm)
variables:
  Vpeak = 15000V
geometry:
  Core [M19_26G] = user_primitive(RMxprt/TransCore.dll, DiaLeg=150mm, DistLeg=422.5mm, DistYoke=831.25mm, Stages=10, ThickCore=20mm, WidthYoke=0mm, InfoCore=0)
  C_L3 [copper] = user_primitive(RMxprt/TransCoil.dll, DistLeg=422.5mm, CoilType=2, WidthIn=169.5mm, DepthIn=169.5mm, RadiusIn=84.75mm, ThickCoil=34mm, HighCoil=545mm, Layers=1, GapLayer=4mm, InfoCore=0)
  C_H3 [copper] = user_primitive(RMxprt/TransCoil.dll, DistLeg=422.5mm, CoilType=2, WidthIn=261.5mm, DepthIn=261.5mm, RadiusIn=130.75mm, ThickCoil=29.9mm, HighCoil=545mm, Layers=1, GapLayer=4mm, InfoCore=0)
  C_L1, C_L2 [copper] = C_L3.separate_bodies()
  C_H1, C_H2 [copper] = C_H3.separate_bodies()
  C_H1_Section1 = C_H1.section(plane=ZX)
  C_H2_Section1 = C_H2.section(plane=ZX)
  C_H3_Section1 = C_H3.section(plane=ZX)
  C_L1_Section1 = C_L1.section(plane=ZX)
  C_L2_Section1 = C_L2.section(plane=ZX)
  C_L3_Section1 = C_L3.section(plane=ZX)
  C_H1_Section1_Separate1 [copper] = C_H1_Section1.separate_bodies()
  C_H1_Section1.delete()
  C_H2_Section1_Separate1 [copper] = C_H2_Section1.separate_bodies()
  C_H2_Section1.delete()
  C_H3_Section1_Separate1 [copper] = C_H3_Section1.separate_bodies()
  C_H3_Section1.delete()
  C_L1_Section1_Separate1 [copper] = C_L1_Section1.separate_bodies()
  C_L1_Section1.delete()
  C_L2_Section1_Separate1 [copper] = C_L2_Section1.separate_bodies()
  C_L2_Section1.delete()
  C_L3_Section1_Separate1 [copper] = C_L3_Section1.separate_bodies()
  C_L3_Section1.delete()
  Region [vacuum] = region(percentage_offset=10 on all sides)
boundaries and excitations:
  Ht_A: Coil Terminal Objects=C_H1_Section1_Separate1 Conductor_number=2922 Winding=Winding_Ht_A Point_out_of_terminal=true
  Ht_B: Coil Terminal Objects=C_H3_Section1_Separate1 Conductor_number=2922 Winding=Winding_Ht_B Point_out_of_terminal=true
  Ht_C: Coil Terminal Objects=C_H2_Section1_Separate1 Conductor_number=2922 Winding=Winding_Ht_C Point_out_of_terminal=true
  Lt_A: Coil Terminal Objects=C_L1_Section1_Separate1 Conductor_number=45 Winding=Winding_Lt_A Point_out_of_terminal=true
  Lt_B: Coil Terminal Objects=C_L2_Section1_Separate1 Conductor_number=45 Winding=Winding_Lt_B Point_out_of_terminal=true
  Lt_C: Coil Terminal Objects=C_L3_Section1_Separate1 Conductor_number=45 Winding=Winding_Lt_C Point_out_of_terminal=true
  Winding_Ht_A: Winding Group Type=Voltage IsSolid=false Current=0mA Resistance=12.83ohm Inductance=0nH Voltage=Vpeak*(1-exp(-50*time))*cos(2*pi*50*time) ParallelBranchesNum=1
  Winding_Ht_B: Winding Group Type=Voltage IsSolid=false Current=0mA Resistance=12.83ohm Inductance=0nH Voltage=Vpeak*(1-exp(-50*time))*cos(2*pi*60*time+(2/3*pi)) ParallelBranchesNum=1
  Winding_Ht_C: Winding Group Type=Voltage IsSolid=false Current=0mA Resistance=12.83ohm Inductance=0nH Voltage=Vpeak*(1-exp(-50*time))*cos(2*pi*60*time+(4/3*pi)) ParallelBranchesNum=1
  Winding_Lt_A: Winding Group Type=Voltage IsSolid=false Current=0mA Resistance=0.00247ohm Inductance=0nH Voltage=0mV ParallelBranchesNum=1
  Winding_Lt_B: Winding Group Type=Voltage IsSolid=false Current=0mA Resistance=0.00247ohm Inductance=0nH Voltage=0mV ParallelBranchesNum=1
  Winding_Lt_C: Winding Group Type=Voltage IsSolid=false Current=0mA Resistance=0.00247ohm Inductance=0nH Voltage=0mV ParallelBranchesNum=1
  core loss on: Core
mesh:
  Length1: LengthBased RefineInside Objects=Core NumMaxElem=10000
  Length2: LengthBased RefineInside Objects=[C_H1, C_H2, C_H3, C_L1, C_L2, C_L3] NumMaxElem=10000
  Length3: LengthBased RefineInside Objects=[Core, C_L3, C_H3, C_L1, C_L2, C_H1, C_H2, C_H1_Section1_Separate1, C_H2_Section1_Separate1, C_H3_Section1_Separate1, C_L1_Section1_Separate1, C_L2_Section1_Separate1, C_L3_Section1_Separate1, Region] NumMaxElem=1000
  initial mesh: GlobalCurvilinear{Apply}
setups:
  Setup1: Transient NonlinearSolverResidual=0.005 ScalarPotential="Second Order" StopTime=0.1s TimeStep=500us SaveFieldsType=Custom SweepRanges{0.08s to 0.1s step 500us} NumberSolveSteps=1 RangeStart=0s RangeEnd=0.1s
reports:
  Winding Plot 1: Current(Winding_Ht_A), Current(Winding_Ht_B), Current(Winding_Ht_C) vs Time on Setup1 : Transient
  Winding Plot 2: Current(Winding_Lt_A), Current(Winding_Lt_B), Current(Winding_Lt_C) vs Time on Setup1 : Transient
  Winding Plot 3: InputVoltage(Winding_Ht_A), InputVoltage(Winding_Ht_B), InputVoltage(Winding_Ht_C) vs Time on Setup1 : Transient
  Winding Plot 5: InducedVoltage(Winding_Ht_A), InducedVoltage(Winding_Ht_B), InducedVoltage(Winding_Ht_C) vs Time on Setup1 : Transient
  Winding Plot 6: InducedVoltage(Winding_Lt_A), InducedVoltage(Winding_Lt_B), InducedVoltage(Winding_Lt_C) vs Time on Setup1 : Transient
  Winding Plot 7: FluxLinkage(Winding_Ht_A), FluxLinkage(Winding_Ht_B), FluxLinkage(Winding_Ht_C) vs Time on Setup1 : Transient
  Winding Plot 8: FluxLinkage(Winding_Lt_A), FluxLinkage(Winding_Lt_B), FluxLinkage(Winding_Lt_C) vs Time on Setup1 : Transient

design Maxwell2DDesign1 (Maxwell 2D, Magnetostatic, XY geometry, model units mm)
geometry:
  Core#6 = user_primitive(RMxprt/TransCore.dll, DiaLeg=150mm, DistLeg=422.5mm, DistYoke=831.25mm, Stages=10, ThickCore=20mm, WidthYoke=0mm, InfoCore=0)
  C_L3#682 = user_primitive(RMxprt/TransCoil.dll, DistLeg=422.5mm, CoilType=2, WidthIn=169.5mm, DepthIn=169.5mm, RadiusIn=84.75mm, ThickCoil=34mm, HighCoil=545mm, Layers=1, GapLayer=4mm, InfoCore=0)
  C_H3#796 = user_primitive(RMxprt/TransCoil.dll, DistLeg=422.5mm, CoilType=2, WidthIn=261.5mm, DepthIn=261.5mm, RadiusIn=130.75mm, ThickCoil=29.9mm, HighCoil=545mm, Layers=1, GapLayer=4mm, InfoCore=0)
  C_L1#836, C_L2#837 = C_L3#682.separate_bodies()
  C_H1#841, C_H2#842 = C_H3#796.separate_bodies()
  C_H1_Section1 = C_H1#841.section(plane=ZX)
  C_H2_Section1 = C_H2#842.section(plane=ZX)
  C_H3_Section1 = C_H3#796.section(plane=ZX)
  C_L1_Section1 = C_L1#836.section(plane=ZX)
  C_L2_Section1 = C_L2#837.section(plane=ZX)
  C_L3_Section1 = C_L3#682.section(plane=ZX)
  C_H1_Section1_Separate1 [copper] = C_H1_Section1.separate_bodies()
  C_H1_Section1.delete()
  C_H2_Section1_Separate1 [copper] = C_H2_Section1.separate_bodies()
  C_H2_Section1.delete()
  C_H3_Section1_Separate1 [copper] = C_H3_Section1.separate_bodies()
  C_H3_Section1.delete()
  C_L1_Section1_Separate1 [copper] = C_L1_Section1.separate_bodies()
  C_L1_Section1.delete()
  C_L2_Section1_Separate1 [copper] = C_L2_Section1.separate_bodies()
  C_L2_Section1.delete()
  C_L3_Section1_Separate1 [copper] = C_L3_Section1.separate_bodies()
  C_L3_Section1.delete()
  Region [vacuum] = region(percentage_offset=10 on all sides)
  Core [M19_26G] = Core#6.section(plane=ZX)
  Core#6.delete()
  Core.rotate(axis=X, angle=-90deg)
  C_L3 [copper] = C_L3#682.section(plane=ZX)
  C_L3#682.delete()
  C_L3.rotate(axis=X, angle=-90deg)
  C_H3 [copper] = C_H3#796.section(plane=ZX)
  C_H3#796.delete()
  C_H3.rotate(axis=X, angle=-90deg)
  C_L1 [copper] = C_L1#836.section(plane=ZX)
  C_L1#836.delete()
  C_L1.rotate(axis=X, angle=-90deg)
  C_L2 [copper] = C_L2#837.section(plane=ZX)
  C_L2#837.delete()
  C_L2.rotate(axis=X, angle=-90deg)
  C_H1 [copper] = C_H1#841.section(plane=ZX)
  C_H1#841.delete()
  C_H1.rotate(axis=X, angle=-90deg)
  C_H2 [copper] = C_H2#842.section(plane=ZX)
  C_H2#842.delete()
  [C_H2, C_H1_Section1_Separate1, C_H2_Section1_Separate1, C_H3_Section1_Separate1, C_L1_Section1_Separate1, C_L2_Section1_Separate1, C_L3_Section1_Separate1].rotate(axis=X, angle=-90deg)
mesh:
  Length3: LengthBased RefineInside Objects=[C_H1_Section1_Separate1, C_H2_Section1_Separate1, C_H3_Section1_Separate1, C_L1_Section1_Separate1, C_L2_Section1_Separate1, C_L3_Section1_Separate1, Region] NumMaxElem=1000
  initial mesh: MeshMethod=AnsoftTAU
