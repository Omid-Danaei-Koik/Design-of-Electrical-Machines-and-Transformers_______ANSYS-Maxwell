# Ansys Electronics Desktop project, version 2022.1
materials:
  vacuum: permittivity=1
  copper: permeability=0.999991 conductivity=58000000
  steel_1008: permeability{HUnit=A_per_meter BUnit=tesla curve (0, 0) (159.2, 0.2402) (318.3, 0.8654) (477.5, 1.1106) (636.6, 1.2458) (795.8, 1.331) (1591.5, 1.5) (3183.1, 1.6) (4774.6, 1.683) (6366.2, 1.741) (7957.7, 1.78) (15915.5, 1.905) (31831, 2.025) (47746.5, 2.085) (63662, 2.13) (79577.5, 2.165) (159155, 2.28) (318310, 2.485) (397887, 2.5851)} conductivity=2000000
  D21_50: permeability{HUnit=A_per_meter BUnit=tesla curve (0, 0) (140, 0.4) (155, 0.45) (171, 0.5) (191, 0.55) (212, 0.6) (237, 0.65) (267, 0.7) (302, 0.75) (340, 0.8) (380, 0.85) (425, 0.9) (476, 0.95) (536, 1) (602, 1.05) (675, 1.1) (765, 1.15) (880, 1.2) (1020, 1.25) (1200, 1.3) (1450, 1.35) (1740, 1.4) (2160, 1.45) (2800, 1.5) (3850, 1.55) (5290, 1.6) (6920, 1.65) (8800, 1.7) (11000, 1.75) (13800, 1.8) (17300, 1.85) (21400, 1.9) (25000, 1.95) (30000, 2)} core_loss_type="Electrical Steel" core_loss_kh=366 core_loss_kc=0.822 core_loss_ke=0.91 mass_density=7820
  cast_aluminum_75C: permeability=1.000021 conductivity=23000000

design Maxwell2DDesign1 (Maxwell 2D, Transient, XY geometry, model units mm)
options: ModelDepth=1meter
variables:
  N = 918
  i = 0.7A
geometry:
  Rectangle1 [copper] = rectangle(corner=(30.5mm, 2mm, 0mm), x_size=4.7mm, y_size=-3.8mm)
  Rectangle1_1 = Rectangle1.duplicate_along_line(step=(5mm, 0mm, 0mm), total=2)
  Rectangle1_Re [copper] = Rectangle1_1.duplicate_around_axis(axis=Z, angle=(360/8) deg, total=8)  # copies kept: 1
  Rectangle1_1.delete()
  Rectangle1_2..Rectangle1_24 [copper] = Rectangle1.duplicate_around_axis(axis=Z, angle=(360/24) deg, total=24)
  Rectangle1_Re_1..Rectangle1_Re_23 [copper] = Rectangle1_Re.duplicate_around_axis(axis=Z, angle=(360/24) deg, total=24)
  Polyline1 = polyline(z=0mm, xy in mm: (27.073973, 0) (27.08, 0.5) (26, 0.5) (26, 3) (18, 2.5) (18, 0) (27.073973, 0), closed, covered)
  Polyline1_1 [cast_aluminum_75C] = Polyline1.duplicate_mirror(point=(22.536986mm, 0mm, 0mm), normal=(0mm, -1mm, 0mm))
  Polyline1_1.unite(Polyline1)
  Polyline1_1.fillet(Vertices=Polyline1_1.vertex(4 of 6) Radius=2mm Setback=0mm)
  Polyline1_1.fillet(Vertices=Polyline1_1.vertex(5 of 6) Radius=2.02mm Setback=0mm)
  Polyline1_1.fillet(Vertices=Polyline1_1.vertex(4 of 6) Radius=2.02mm Setback=0mm)
  Polyline1_1.fillet(Vertices=Polyline1_1.vertex(5 of 6) Radius=2mm Setback=0mm)
  Polyline1_1_1..Polyline1_1_16 [cast_aluminum_75C] = Polyline1_1.duplicate_around_axis(axis=Z, angle=(360/17) deg, total=17)
  Circle5 [steel_1008] = circle(normal=Z, centre=(0mm, 0mm, 0mm), radius=8.9442719mm)
  Polyline5 = polyline(z=0mm, xy in mm: (27.018512, 0) (27.014, 0.5) (26, 0.5) (26, 3) (18, 2.5) (18, 0) (27.018512, 0), closed, covered)
  Polyline5.fillet(Vertices=Rectangle3.vertex(4 of 6) Radius=2mm Setback=0mm)
  Polyline5.fillet(Vertices=Rectangle3.vertex(5 of 6) Radius=2.02mm Setback=0mm)
  Polyline6 = polyline(z=0mm, xy in mm: (27.014, 0.5) (27.0142, 0.5) (27.015, -0.5) (27.014, -0.5) (27.014, 0.5), closed, covered)
  Polyline6.unite(Polyline5)
  Polyline2_1 = Polyline6.duplicate_mirror(point=(24mm, 0mm, 0mm), normal=(0mm, -1mm, 0mm))
  Polyline6.unite(Polyline2_1)
  Rectangle4 = rectangle(corner=(27.01mm, 0.5mm, 0mm), x_size=0.0075mm, y_size=-1mm)
  Rectangle4.unite(Polyline6)
  Rectangle2 = rectangle(corner=(27mm, 0.44mm, 0mm), x_size=0.018mm, y_size=-0.88mm)
  Rectangle2.unite(Rectangle4)
  Rectangle3 = rectangle(corner=(27.02mm, 0.44mm, 0mm), x_size=-0.08mm, y_size=-0.9mm)
  Rectangle3.unite(Rectangle2)
  Rectangle3_1..Rectangle3_16 = Rectangle3.duplicate_around_axis(axis=Z, angle=(360/17) deg, total=17)
  [Rectangle3, Rectangle3_1..Rectangle3_16].delete()
  Circle7 [vacuum] = circle(normal=Z, centre=(0mm, 0mm, 0mm), radius=27.236006mm)
  Circle8 [vacuum] = circle(normal=Z, centre=(0mm, 0mm, 0mm), radius=60.207973mm)
  Circle1 [vacuum] = imported_body()
  Circle6 [D21_50] = imported_body()
motion:
  MotionSetup1: Band Move_Type=Rotate Coordinate_System=Global Axis=Z Is_Positive=true InitPos=-118deg Angular_Velocity=1380rpm Objects=Circle7
  Moving1: Moving Objects=[Polyline1_1, Polyline1_1_1..Polyline1_1_16, Circle5, Circle6]
boundaries and excitations:
  VectorPotential1: Vector Potential Edges=Circle7.edge(1 of 1) Value=0
  VectorPotential2: Vector Potential Edges=Circle8.edge(1 of 1) Value=0
  Current_1: Current Objects=Polyline1_1 Current=0mA IsSolid=true IsPositive=true
  Current_2: Current Objects=Polyline1_1_1 Current=0mA IsSolid=true IsPositive=true
  Current_3: Current Objects=Polyline1_1_2 Current=0mA IsSolid=true IsPositive=true
  Current_4: Current Objects=Polyline1_1_3 Current=0mA IsSolid=true IsPositive=true
  Current_5: Current Objects=Polyline1_1_4 Current=0mA IsSolid=true IsPositive=true
  Current_6: Current Objects=Polyline1_1_5 Current=0mA IsSolid=true IsPositive=true
  Current_7: Current Objects=Polyline1_1_6 Current=0mA IsSolid=true IsPositive=true
  Current_8: Current Objects=Polyline1_1_7 Current=0mA IsSolid=true IsPositive=true
  Current_9: Current Objects=Polyline1_1_8 Current=0mA IsSolid=true IsPositive=true
  Current_10: Current Objects=Polyline1_1_9 Current=0mA IsSolid=true IsPositive=true
  Current_11: Current Objects=Polyline1_1_10 Current=0mA IsSolid=true IsPositive=true
  Current_12: Current Objects=Polyline1_1_11 Current=0mA IsSolid=true IsPositive=true
  Current_13: Current Objects=Polyline1_1_12 Current=0mA IsSolid=true IsPositive=true
  Current_14: Current Objects=Polyline1_1_13 Current=0mA IsSolid=true IsPositive=true
  Current_15: Current Objects=Polyline1_1_14 Current=0mA IsSolid=true IsPositive=true
  Current_16: Current Objects=Polyline1_1_15 Current=0mA IsSolid=true IsPositive=true
  Current_17: Current Objects=Polyline1_1_16 Current=0mA IsSolid=true IsPositive=true
  coil_s_p_1: Current Objects=Rectangle1 Current=N*i IsSolid=true IsPositive=true
  coil_s_p_2: Current Objects=Rectangle1_2 Current=N*i IsSolid=true IsPositive=true
  coil_s_p_3: Current Objects=Rectangle1_3 Current=N*i IsSolid=true IsPositive=true
  coil_s_p_4: Current Objects=Rectangle1_4 Current=N*i IsSolid=true IsPositive=true
  coil_s_p_5: Current Objects=Rectangle1_5 Current=N*i IsSolid=true IsPositive=true
  coil_s_p_6: Current Objects=Rectangle1_6 Current=N*i IsSolid=true IsPositive=true
  coil_s_p_7: Current Objects=Rectangle1_7 Current=N*i IsSolid=true IsPositive=true
  coil_s_p_8: Current Objects=Rectangle1_8 Current=N*i IsSolid=true IsPositive=true
  coil_s_p_9: Current Objects=Rectangle1_9 Current=N*i IsSolid=true IsPositive=true
  coil_s_p_10: Current Objects=Rectangle1_10 Current=N*i IsSolid=true IsPositive=true
  coil_s_p_11: Current Objects=Rectangle1_11 Current=N*i IsSolid=true IsPositive=true
  coil_s_p_12: Current Objects=Rectangle1_12 Current=N*i IsSolid=true IsPositive=true
  coil_s_p_13: Current Objects=Rectangle1_13 Current=N*i IsSolid=true IsPositive=true
  coil_s_p_14: Current Objects=Rectangle1_14 Current=N*i IsSolid=true IsPositive=true
  coil_s_p_15: Current Objects=Rectangle1_15 Current=N*i IsSolid=true IsPositive=true
  coil_s_p_16: Current Objects=Rectangle1_16 Current=N*i IsSolid=true IsPositive=true
  coil_s_p_17: Current Objects=Rectangle1_17 Current=N*i IsSolid=true IsPositive=true
  coil_s_p_18: Current Objects=Rectangle1_18 Current=N*i IsSolid=true IsPositive=true
  coil_s_p_19: Current Objects=Rectangle1_19 Current=N*i IsSolid=true IsPositive=true
  coil_s_p_20: Current Objects=Rectangle1_20 Current=N*i IsSolid=true IsPositive=true
  coil_s_p_21: Current Objects=Rectangle1_21 Current=N*i IsSolid=true IsPositive=true
  coil_s_p_22: Current Objects=Rectangle1_22 Current=N*i IsSolid=true IsPositive=true
  coil_s_p_23: Current Objects=Rectangle1_23 Current=N*i IsSolid=true IsPositive=true
  coil_s_p_24: Current Objects=Rectangle1_24 Current=N*i IsSolid=true IsPositive=true
  coil_s_N_1: Current Objects=Rectangle1_Re Current=N*i IsSolid=true IsPositive=false
  coil_s_N_2: Current Objects=Rectangle1_Re_1 Current=N*i IsSolid=true IsPositive=false
  coil_s_N_3: Current Objects=Rectangle1_Re_2 Current=N*i IsSolid=true IsPositive=false
  coil_s_N_4: Current Objects=Rectangle1_Re_3 Current=N*i IsSolid=true IsPositive=false
  coil_s_N_5: Current Objects=Rectangle1_Re_4 Current=N*i IsSolid=true IsPositive=false
  coil_s_N_6: Current Objects=Rectangle1_Re_5 Current=N*i IsSolid=true IsPositive=false
  coil_s_N_7: Current Objects=Rectangle1_Re_6 Current=N*i IsSolid=true IsPositive=false
  coil_s_N_8: Current Objects=Rectangle1_Re_7 Current=N*i IsSolid=true IsPositive=false
  coil_s_N_9: Current Objects=Rectangle1_Re_8 Current=N*i IsSolid=true IsPositive=false
  coil_s_N_10: Current Objects=Rectangle1_Re_9 Current=N*i IsSolid=true IsPositive=false
  coil_s_N_11: Current Objects=Rectangle1_Re_10 Current=N*i IsSolid=true IsPositive=false
  coil_s_N_12: Current Objects=Rectangle1_Re_11 Current=N*i IsSolid=true IsPositive=false
  coil_s_N_13: Current Objects=Rectangle1_Re_12 Current=N*i IsSolid=true IsPositive=false
  coil_s_N_14: Current Objects=Rectangle1_Re_13 Current=N*i IsSolid=true IsPositive=false
  coil_s_N_15: Current Objects=Rectangle1_Re_14 Current=N*i IsSolid=true IsPositive=false
  coil_s_N_16: Current Objects=Rectangle1_Re_15 Current=N*i IsSolid=true IsPositive=false
  coil_s_N_17: Current Objects=Rectangle1_Re_16 Current=N*i IsSolid=true IsPositive=false
  coil_s_N_18: Current Objects=Rectangle1_Re_17 Current=N*i IsSolid=true IsPositive=false
  coil_s_N_19: Current Objects=Rectangle1_Re_18 Current=N*i IsSolid=true IsPositive=false
  coil_s_N_20: Current Objects=Rectangle1_Re_19 Current=N*i IsSolid=true IsPositive=false
  coil_s_N_21: Current Objects=Rectangle1_Re_20 Current=N*i IsSolid=true IsPositive=false
  coil_s_N_22: Current Objects=Rectangle1_Re_21 Current=N*i IsSolid=true IsPositive=false
  coil_s_N_23: Current Objects=Rectangle1_Re_22 Current=N*i IsSolid=true IsPositive=false
  coil_s_N_24: Current Objects=Rectangle1_Re_23 Current=N*i IsSolid=true IsPositive=false
mesh:
  winding: LengthBased RefineInside Objects=[Polyline1_1, Polyline1_1_1..Polyline1_1_16, Rectangle1, Rectangle1_2..Rectangle1_24, Rectangle1_Re, Rectangle1_Re_1..Rectangle1_Re_23] NumMaxElem=1000
  CylindricalGap1: CylindricalGap Objects=Circle7
  initial mesh: MeshMethod=AnsoftTAU
setups:
  Setup1: Transient NonlinearSolverResidual=0.0001 StopTime=0.01s TimeStep=0.001s SaveFieldsType=Custom SweepRanges{0.001s to 0.01s step 0.001s} NumberSolveSteps=1 RangeStart=0s RangeEnd=0.1s InitialTimeStep=0.002s MinTimeStep=0.001s MaxTimeStep=0.003s TimeStepErrTolerance=0.0001
field plots:
  Mag_B1: B over Rectangle1, Rectangle1_Re, Rectangle1_2..Rectangle1_24, Rectangle1_Re_1..Rectangle1_Re_23, Polyline1_1, Polyline1_1_1..Polyline1_1_16, Circle5, Circle1, Circle6, Circle7, Circle8 on Setup1 : Transient at Time=0.01s
